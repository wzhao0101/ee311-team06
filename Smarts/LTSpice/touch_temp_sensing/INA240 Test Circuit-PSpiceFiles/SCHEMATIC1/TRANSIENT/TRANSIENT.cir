** Profile: "SCHEMATIC1-TRANSIENT"  [ C:\Users\a0282827\Downloads\PSpice Library\INA240\INA240_PSpice\ina240 test circuit-pspicefiles\schematic1\transient.sim ]

** Creating circuit file "TRANSIENT.cir"
** WARNING: THIS AUTOMATICALLY GENERATED FILE MAY BE OVERWRITTEN BY SUBSEQUENT SIMULATIONS

*Libraries:
* Profile Libraries :
* Local Libraries :
.LIB "../../../ina240a4.lib"
.LIB "../../../ina240a3.lib"
.LIB "../../../ina240a2.lib"
.LIB "../../../ina240a1.lib"
* From [PSPICE NETLIST] section of C:\Users\a0282827\AppData\Roaming\SPB_Data\cdssetup\OrCAD_PSpice/16.6.0/PSpice.ini file:
.lib "nom.lib"

*Analysis directives:
.TRAN  0 100u 0 100n
.OPTIONS ADVCONV
.PROBE64 V(alias(*)) I(alias(*)) W(alias(*)) D(alias(*)) NOISE(alias(*))
.INC "..\SCHEMATIC1.net"

.END
